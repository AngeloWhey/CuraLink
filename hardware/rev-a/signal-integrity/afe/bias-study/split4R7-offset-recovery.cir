* CuraLink Rev A: actual LTspice run with original TI family macro-model equations
.include models/tlv9002-namespaced.lib
.include models/tlv9052-namespaced.lib
.options numdgt=7 plotwinsize=0
.temp 27
.include split4R7.lib
VDD AVDD_3V0 0 DC 3
VCOMMON COMMON_SRC 0 DC 0 AC 0
VCH1 SRC_CH1 COMMON_SRC PWL(0 0 10m 0 10.001m 0.1 600m 0.1 600.001m 0 1.2 0 1.200001 -0.1 1.8 -0.1 1.800001 0 2.4 0)
VCH2 SRC_CH2 COMMON_SRC DC 0 AC 0
VCH3 SRC_CH3 COMMON_SRC DC 0 AC 0
VCH4 SRC_CH4 COMMON_SRC DC 0 AC 0
VCH5 SRC_CH5 COMMON_SRC DC 0 AC 0
VCH6 SRC_CH6 COMMON_SRC DC 0 AC 0
VCH7 SRC_CH7 COMMON_SRC DC 0 AC 0
VCH8 SRC_CH8 COMMON_SRC DC 0 AC 0
VREF SRC_REF COMMON_SRC DC 0 AC 0
.save V(AVDD_3V0) V(VMID_RAW) V(VMID_BUF) V(VMID) V(REF_PLUS) V(REF_PRE) V(CH1_PLUS) V(CH1_MINUS) V(CH1_PRE) V(CH1_DIFF_PLUS) V(CH1_DIFF_MINUS) V(CH1_HP) V(CH1_LP1_OUT) V(AFE_OUT_1) V(ADC_IN_1) V(FFC_CH1) V(SRC_CH1) V(SRC_REF) I(VDD) V(AFE_OUT_2) V(AFE_OUT_3) V(AFE_OUT_4) V(AFE_OUT_5) V(AFE_OUT_6) V(AFE_OUT_7) V(AFE_OUT_8)
.save V(VMID_LP1) V(VMID_LP2) V(VMID_LP1_BUF) V(VMID_LP2_BUF)
.tran 0 4 0 100u
.end
