* CuraLink: CH1-only circuit crosstalk; added Cx is an assumed sensitivity
.include models/tlv9002-namespaced.lib
.include models/tlv9052-namespaced.lib
.options numdgt=7 plotwinsize=0
.temp 27
.include canonical-afe.lib
VDD AVDD_3V0 0 DC 3
VCOMMON COMMON_SRC 0 DC 0 AC 0
VCH1 SRC_CH1 COMMON_SRC DC 0 AC 0
VCH2 SRC_CH2 COMMON_SRC DC 0 AC 0
VCH3 SRC_CH3 COMMON_SRC DC 0 AC 0
VCH4 SRC_CH4 COMMON_SRC DC 0 AC 0
VCH5 SRC_CH5 COMMON_SRC DC 0 AC 0
VCH6 SRC_CH6 COMMON_SRC DC 0 AC 0
VCH7 SRC_CH7 COMMON_SRC DC 0 AC 0
VCH8 SRC_CH8 COMMON_SRC DC 0 AC 0
VREF SRC_REF COMMON_SRC DC 0 AC 0
.save V(AVDD_3V0) V(VMID_RAW) V(VMID_BUF) V(VMID) V(REF_PLUS) V(REF_PRE) V(SRC_CH1) V(FFC_CH1) V(FFC_CH2) V(CH1_PLUS) V(CH2_PLUS) V(AFE_OUT_1) V(AFE_OUT_2) V(AFE_OUT_3) V(AFE_OUT_4) V(AFE_OUT_5) V(AFE_OUT_6) V(AFE_OUT_7) V(AFE_OUT_8) V(ADC_IN_1) V(ADC_IN_2) V(ADC_IN_3) V(ADC_IN_4) V(ADC_IN_5) V(ADC_IN_6) V(ADC_IN_7) V(ADC_IN_8) I(VDD)
.save V(AFE_OUT_1) V(AFE_OUT_2) V(AFE_OUT_3) V(AFE_OUT_4) V(AFE_OUT_5) V(AFE_OUT_6) V(AFE_OUT_7) V(AFE_OUT_8) V(AFE_SPARE_C) V(AFE_SPARE_D) V(AVDD_3V0) V(CH1_DIFF_MINUS) V(CH1_DIFF_PLUS) V(CH1_HP) V(CH1_LP1_MINUS) V(CH1_LP1_OUT) V(CH1_LP1_PLUS) V(CH1_LP2_MINUS) V(CH1_LP2_PLUS) V(CH1_MINUS) V(CH1_PLUS) V(CH1_PRE) V(CH2_DIFF_MINUS) V(CH2_DIFF_PLUS) V(CH2_HP) V(CH2_LP1_MINUS) V(CH2_LP1_OUT) V(CH2_LP1_PLUS) V(CH2_LP2_MINUS) V(CH2_LP2_PLUS) V(CH2_MINUS) V(CH2_PLUS) V(CH2_PRE) V(CH3_DIFF_MINUS) V(CH3_DIFF_PLUS) V(CH3_HP) V(CH3_LP1_MINUS) V(CH3_LP1_OUT) V(CH3_LP1_PLUS) V(CH3_LP2_MINUS) V(CH3_LP2_PLUS) V(CH3_MINUS) V(CH3_PLUS) V(CH3_PRE) V(CH4_DIFF_MINUS) V(CH4_DIFF_PLUS) V(CH4_HP) V(CH4_LP1_MINUS) V(CH4_LP1_OUT) V(CH4_LP1_PLUS) V(CH4_LP2_MINUS) V(CH4_LP2_PLUS) V(CH4_MINUS) V(CH4_PLUS) V(CH4_PRE) V(CH5_DIFF_MINUS) V(CH5_DIFF_PLUS) V(CH5_HP) V(CH5_LP1_MINUS) V(CH5_LP1_OUT) V(CH5_LP1_PLUS) V(CH5_LP2_MINUS) V(CH5_LP2_PLUS) V(CH5_MINUS) V(CH5_PLUS) V(CH5_PRE) V(CH6_DIFF_MINUS) V(CH6_DIFF_PLUS) V(CH6_HP) V(CH6_LP1_MINUS) V(CH6_LP1_OUT) V(CH6_LP1_PLUS) V(CH6_LP2_MINUS) V(CH6_LP2_PLUS) V(CH6_MINUS) V(CH6_PLUS) V(CH6_PRE) V(CH7_DIFF_MINUS) V(CH7_DIFF_PLUS) V(CH7_HP) V(CH7_LP1_MINUS) V(CH7_LP1_OUT) V(CH7_LP1_PLUS) V(CH7_LP2_MINUS) V(CH7_LP2_PLUS) V(CH7_MINUS) V(CH7_PLUS) V(CH7_PRE) V(CH8_DIFF_MINUS) V(CH8_DIFF_PLUS) V(CH8_HP) V(CH8_LP1_MINUS) V(CH8_LP1_OUT) V(CH8_LP1_PLUS) V(CH8_LP2_MINUS) V(CH8_LP2_PLUS) V(CH8_MINUS) V(CH8_PLUS) V(CH8_PRE) V(REF_MINUS) V(REF_PLUS) V(REF_PRE) V(VMID_BUF) V(VMID_RAW)
.op
.end
