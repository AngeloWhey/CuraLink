* CuraLink: CH1-only circuit crosstalk; added Cx is an assumed sensitivity
.include models/tlv9002-namespaced.lib
.include models/tlv9052-namespaced.lib
.options numdgt=7 plotwinsize=0
.temp 27
.include canonical-afe.lib
VDD AVDD_3V0 0 DC 3
VCOMMON COMMON_SRC 0 DC 0 AC 0
VCH1 SRC_CH1 COMMON_SRC DC 0 AC 1
VCH2 SRC_CH2 COMMON_SRC DC 0 AC 0
VCH3 SRC_CH3 COMMON_SRC DC 0 AC 0
VCH4 SRC_CH4 COMMON_SRC DC 0 AC 0
VCH5 SRC_CH5 COMMON_SRC DC 0 AC 0
VCH6 SRC_CH6 COMMON_SRC DC 0 AC 0
VCH7 SRC_CH7 COMMON_SRC DC 0 AC 0
VCH8 SRC_CH8 COMMON_SRC DC 0 AC 0
VREF SRC_REF COMMON_SRC DC 0 AC 0
C_ASSUMED AFE_OUT_1 CH2_PLUS {Cx}
.step param Cx list 0 10f 20f 50f 100f 200f 500f 1p
.save V(AVDD_3V0) V(VMID_RAW) V(VMID_BUF) V(VMID) V(REF_PLUS) V(REF_PRE) V(SRC_CH1) V(FFC_CH1) V(FFC_CH2) V(CH1_PLUS) V(CH2_PLUS) V(AFE_OUT_1) V(AFE_OUT_2) V(AFE_OUT_3) V(AFE_OUT_4) V(AFE_OUT_5) V(AFE_OUT_6) V(AFE_OUT_7) V(AFE_OUT_8) V(ADC_IN_1) V(ADC_IN_2) V(ADC_IN_3) V(ADC_IN_4) V(ADC_IN_5) V(ADC_IN_6) V(ADC_IN_7) V(ADC_IN_8) I(VDD)
.ac dec 100 300 7k
.end
