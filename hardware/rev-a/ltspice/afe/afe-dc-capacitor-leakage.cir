* CuraLink Rev A: actual LTspice run with original TI family macro-model equations
.include models/tlv9002-namespaced.lib
.include models/tlv9052-namespaced.lib
.options numdgt=7 plotwinsize=0
.temp 25
.include canonical-afe.lib
VDD AVDD_3V0 0 DC 3
VCOMMON COMMON_SRC 0 DC 0 AC 0
VCH1 SRC_CH1 COMMON_SRC DC 0 AC 0
VCH2 SRC_CH2 COMMON_SRC DC 0 AC 0
VCH3 SRC_CH3 COMMON_SRC DC 0 AC 0
VCH4 SRC_CH4 COMMON_SRC DC 0 AC 0
VCH5 SRC_CH5 COMMON_SRC DC 0 AC 0
VCH6 SRC_CH6 COMMON_SRC DC 0 AC 0
VCH7 SRC_CH7 COMMON_SRC DC 0 AC 0
VCH8 SRC_CH8 COMMON_SRC DC 0 AC 0
VREF SRC_REF COMMON_SRC DC 0 AC 0
.save V(AVDD_3V0) V(VMID_RAW) V(VMID_BUF) V(VMID) V(REF_PLUS) V(REF_PRE) V(CH1_PLUS) V(CH1_MINUS) V(CH1_PRE) V(CH1_DIFF_PLUS) V(CH1_DIFF_MINUS) V(CH1_HP) V(CH1_LP1_OUT) V(AFE_OUT_1) V(ADC_IN_1) V(FFC_CH1) V(SRC_CH1) V(SRC_REF) I(VDD) V(AFE_OUT_2) V(AFE_OUT_3) V(AFE_OUT_4) V(AFE_OUT_5) V(AFE_OUT_6) V(AFE_OUT_7) V(AFE_OUT_8)
* KEMET C0G datasheet IR lower limit: 100 GOhm at 25C for 10nF; 10G post-environment limit
* 1G/100Meg are deliberate board/leakage sensitivity cases, not capacitor specifications
RLEAK_C1001 CH1_LIMIT CH1_PLUS {RLEAK}
RLEAK_C1002 CH1_PRE CH1_HP_CH {RLEAK}
RLEAK_C1003 REF_PRE CH1_HP_REF {RLEAK}
RLEAK_C1008 CH2_LIMIT CH2_PLUS {RLEAK}
RLEAK_C1009 CH2_PRE CH2_HP_CH {RLEAK}
RLEAK_C1010 REF_PRE CH2_HP_REF {RLEAK}
RLEAK_C1015 CH3_LIMIT CH3_PLUS {RLEAK}
RLEAK_C1016 CH3_PRE CH3_HP_CH {RLEAK}
RLEAK_C1017 REF_PRE CH3_HP_REF {RLEAK}
RLEAK_C1022 CH4_LIMIT CH4_PLUS {RLEAK}
RLEAK_C1023 CH4_PRE CH4_HP_CH {RLEAK}
RLEAK_C1024 REF_PRE CH4_HP_REF {RLEAK}
RLEAK_C1029 CH5_LIMIT CH5_PLUS {RLEAK}
RLEAK_C1030 CH5_PRE CH5_HP_CH {RLEAK}
RLEAK_C1031 REF_PRE CH5_HP_REF {RLEAK}
RLEAK_C1036 CH6_LIMIT CH6_PLUS {RLEAK}
RLEAK_C1037 CH6_PRE CH6_HP_CH {RLEAK}
RLEAK_C1038 REF_PRE CH6_HP_REF {RLEAK}
RLEAK_C1043 CH7_LIMIT CH7_PLUS {RLEAK}
RLEAK_C1044 CH7_PRE CH7_HP_CH {RLEAK}
RLEAK_C1045 REF_PRE CH7_HP_REF {RLEAK}
RLEAK_C1050 CH8_LIMIT CH8_PLUS {RLEAK}
RLEAK_C1051 CH8_PRE CH8_HP_CH {RLEAK}
RLEAK_C1052 REF_PRE CH8_HP_REF {RLEAK}
RLEAK_C1057 REF_LIMIT REF_PLUS {RLEAK}
.param RLEAK=100G
.step param RLEAK list 100G 10G 1G 100Meg
.dc VCH1 -0.1 0.1 0.005
.end
