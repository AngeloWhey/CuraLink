* CuraLink U505 FIELD_ABSENT DC test, TI TLV3012B manufacturer macro.
* CTRL_3V is a separately regulated ideal 3V source in this isolated fixture.
.include "sources/tlv3012b-spice/TLV3012B/tlv3012b.LIB"
VCTRL CTRL_3V0 0 3
VRAW WPT_RAW 0 0
R516 WPT_RAW WPT_SENSE 100k
R517 WPT_SENSE 0 10k
C514 WPT_SENSE 0 100p
D509 0 WPT_SENSE D509_APPROX
.model D509_APPROX D(Is=74n N=1.07 Rs=5 BV=30 Ibv=100u Cjo=10p)
VREF REF_1V242 0 1.242
R518 REF_1V242 WPT_THRESHOLD 100k
R519 WPT_THRESHOLD 0 20k
R520 FIELD_ABSENT WPT_THRESHOLD 1.5Meg
XU505 WPT_THRESHOLD WPT_SENSE CTRL_3V0 0 FIELD_ABSENT REF_UNUSED TLV3012B
RFIELD FIELD_ABSENT 0 1Meg
.dc VRAW -18 18 .005
.meas DC field_at5 FIND V(FIELD_ABSENT) AT=5
.meas DC max_sense MAX V(WPT_SENSE)
.meas DC min_sense MIN V(WPT_SENSE)
.save V(WPT_RAW) V(WPT_SENSE) V(WPT_THRESHOLD) V(FIELD_ABSENT)
.options plotwinsize=0
.end
