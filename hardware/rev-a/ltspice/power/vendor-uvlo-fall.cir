* TI TLV3012B vendor U504 battery UVLO fixture, regulated control rail held3V.
.include "sources/tlv3012b-spice/TLV3012B/tlv3012b.LIB"
VCTRL CTRL_3V0 0 3
VPACK PACK_PLUS 0 4
R513 PACK_PLUS BAT_SENSE 1Meg
R514 BAT_SENSE 0 510k
R515 BAT_OK BAT_SENSE 10Meg
C513 BAT_SENSE 0 1n
XU504 BAT_SENSE REF_1V242 CTRL_3V0 0 BAT_OK REF_1V242 TLV3012B
RTEST BAT_OK 0 1Meg
.dc VPACK 4.5 2.2 -.001
.save V(PACK_PLUS) V(BAT_SENSE) V(BAT_OK) V(REF_1V242)
.options plotwinsize=0
.end
