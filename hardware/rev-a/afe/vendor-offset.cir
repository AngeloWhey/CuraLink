* CuraLink candidate: real 3V supplies, one channel + shared REF + VMID
* TI dual family macro-model represents one amplifier per instance; package cross-talk not modeled.
.include vendor/combined-namespaced.lib
VS AVDD 0 DC 3
VMRAW VMID_RAW 0 DC 1.5
Vsig src 0 PWL(0 1.5 5m 1.5 5.001m 1.6 50m 1.6 50.001m 1.5 150m 1.5 150.001m 1.4 250m 1.4 250.001m 1.5 500m 1.5)
Vref refsrc 0 DC 1.5 AC 0
Xvmid VMID_RAW VMID_BUF AVDD 0 VMID_BUF TLV9002_TLV9002
Rvmid VMID_BUF VMID 47
Cvmid VMID 0 4.7u
.nodeset v(VMID_BUF)=1.5 v(VMID)=1.5 v(cho)=1.5 v(refo)=1.5 v(do)=1.5 v(lp1o)=1.5 v(lp2o)=1.5
Rchsource src chelec 47000
Rchprotect chelec chcap 5100
Cchac chcap chp 1e-08
Rchbias chp VMID 22000000
Rchrg chm VMID 1000
Rchrf cho chm 10000
Rrefsource refsrc refelec 47000
Rrefprotect refelec refcap 5100
Crefac refcap refp 1e-08
Rrefbias refp VMID 22000000
Rrefrg refm VMID 1000
Rrefrf refo refm 10000
Chpch cho hpc 1e-08
Rrin hpc dm 51100
Chpref refo hpr 1e-08
Rrref hpr dp 51100
Rlp1r1 do lp1a 22600
Rlp1r2 lp1a lp1p 22600
Clp1c1 lp1a lp1o 1e-09
Clp1c2 lp1p VMID 1e-09
Rlp1rg lp1m VMID 10000
Rlp1rf lp1o lp1m 1500
Rlp2r1 lp1o lp2a 22600
Rlp2r2 lp2a lp2p 22600
Clp2c1 lp2a lp2o 1e-09
Clp2c2 lp2p VMID 1e-09
Rlp2rg lp2m VMID 10000
Rlp2rf lp2o lp2m 12400
Radciso lp2o adc 150
Cadcreservoir adc 0 4.7e-10
Rrfd_1 do rfd_mid 909000
Rrfd_2 rfd_mid dm 909000
Rrbald_1 dp rbald_mid 909000
Rrbald_2 rbald_mid VMID 909000
Cchesdtraceffc chelec 0 2.25e-11
Crefesdtraceffc refelec 0 2.25e-11
Xch chp chm AVDD 0 cho TLV9002_TLV9002
Xref refp refm AVDD 0 refo TLV9002_TLV9002
Xdiff dp dm AVDD 0 do TLV9002_TLV9002
Xlp1 lp1p lp1m AVDD 0 lp1o TLV9002_TLV9002
Xlp2 lp2p lp2m AVDD 0 lp2o TLV9052_TLV9052
.control
set wr_singlescale
set wr_vecnames
tran 20u 500m 0 40u
wrdata vendor-offset.csv v(src) v(cho) v(adc) v(VMID)
quit
.endc
.end
