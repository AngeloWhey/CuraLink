Four-channel bench MCU power path, protected input boundary to digital rail
* PWLs impose arrival/removal and an 86ms RUN inhibit. Comparator/charger
* loops, the cell, RF, BOR algorithms and silicon radio currents are outside
* this fixture. Sources include an assumed 0.25 ohm path resistance.
.include "../ltspice/power/sources/tps7a20-spice/tps7a20-adj_trans.lib"
.param V_out=3.0
Vrun run_src 0 PWL(0 3.8 4.9m 3.8 5m 0 96m 0 96.1m 3.8 104m 3.8)
Vchg chg_src 0 PWL(0 0 4m 0 4.5m 4.72 10m 4.72 10.1m 0 104m 0)
Rrun run_src SYS_RAW .25
Rchg chg_src CHG_IN .25
D610 SYS_RAW SYS_DIGITAL_IN OR_EST
D611 CHG_IN SYS_DIGITAL_IN OR_EST
* Project SS14 curve estimate, no manufacturer leakage or PVT qualification.
.model OR_EST D(Is=2u N=1.15 Rs=.04 BV=40 Ibv=1m Cjo=60p)
C527 SYS_DIGITAL_IN 0 2.2u
XU513 SYS_DIGITAL_IN 0 SYS_DIGITAL_IN NC DVDD TPS7A20_ADJ_TRANS
* Aggregate effective DVDD bypass scenario (two nominal 10uF plus smaller
* bypasses on PCB). A resistor load falls with voltage during shutdown.
Cout DVDD 0 15u
Rbase DVDD 0 600
Vburst cmd 0 PWL(0 0 6m 0 6.002m 1 7m 1 7.002m 0 104m 0)
Bburst DVDD 0 I=V(DVDD)*V(cmd)/200
.tran 0 104m 0 5u
.meas TRAN run_v FIND V(DVDD) AT=3.5m
.meas TRAN charge_v FIND V(DVDD) AT=5.8m
.meas TRAN burst_v MIN V(DVDD) FROM=6m TO=7m
.meas TRAN release_floor MIN V(DVDD) FROM=10.1m TO=96m
.meas TRAN recovered_v FIND V(DVDD) AT=102m
.meas TRAN below_1p71 WHEN V(DVDD)=1.71 FALL=1
.save V(DVDD) V(SYS_DIGITAL_IN) V(SYS_RAW) V(CHG_IN) I(Vrun) I(Vchg)
.options plotwinsize=0
.end
