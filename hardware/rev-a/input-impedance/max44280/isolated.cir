* Driven gain-11 MAX44280 input with ideal midrail, de-embedded from trace, ESD and bias.
.lib MAX44280.sub
.options numdgt=8 plotwinsize=0
.temp 27
Vdd vdd 0 3
Vmid mid 0 1.5
Vdrive inp 0 DC 1.5 AC 1
Rf out minus 10k
Rg minus mid 1k
Xu inp minus vdd 0 out vdd MAX44280
.ac dec 80 7 70Meg
.save V(out) I(Vdrive)
.end
