* CuraLink candidate one channel + shared reference, all voltages relative to ideal VMID
* Updated 2026-09-22 for low-C connector ESD, 5.1k input limiting and no waveform ADC.
* Linear small-signal only. This netlist has NOT been run in SPICE or vendor models.
* CH/REF model values repeat for eight channels; cable and fixture parasitics omitted.
Vsig src 0 AC 1
Vref refsrc 0 AC 0
Rchsource src chelec 47000
Cchesd chelec 0 0.5e-12
Rchprotect chelec chcap 5100
Cchac chcap chp 1e-08
Rchbias chp 0 22000000
Cchcin chp 0 7e-12
Rchrg chm 0 1000
Rchrf cho chm 10000
Rrefsource refsrc refelec 47000
Crefesd refelec 0 0.5e-12
Rrefprotect refelec refcap 5100
Crefac refcap refp 1e-08
Rrefbias refp 0 22000000
Crefcin refp 0 7e-12
Rrefrg refm 0 1000
Rrefrf refo refm 10000
Chpch cho hpc 1e-08
Rrin hpc dm 53600
Rrfd do dm 1870000
Chpref refo hpr 1e-08
Rrref hpr dp 53600
Rrbald dp 0 1870000
Rlp1r1 do lp1a 22600
Rlp1r2 lp1a lp1p 22600
Clp1c1 lp1a lp1o 1e-09
Clp1c2 lp1p 0 1e-09
Rlp1rg lp1m 0 10000
Rlp1rf lp1o lp1m 1500
Rlp2r1 lp1o lp2a 22600
Rlp2r2 lp2a lp2p 22600
Clp2c1 lp2a lp2o 1e-09
Clp2c2 lp2p 0 1e-09
Rlp2rg lp2m 0 10000
Rlp2rf lp2o lp2m 12400
Routiso lp2o couple 100
Coutdc couple det 1e-07
Rdetbias det 0 100000
Cdetcap det 0 1e-11
Xch chp chm cho OP_LINEAR
Xref refp refm refo OP_LINEAR
Xdiff dp dm do OP_LINEAR
Xlp1 lp1p lp1m lp1o OP_LINEAR
Xlp2 lp2p lp2m lp2o OP_LINEAR
.subckt OP_LINEAR p m o
Eol internal 0 p m 100000
Rdom internal pole 1k
Cdom pole 0 1.59154943092u
Ebuf o 0 pole 0 1
.ends OP_LINEAR
* Output buffer preserves the Python model zero output impedance.
* Replace OP_LINEAR with vendor macro-models before using this for release.
.ac dec 100 0.1 1Meg
.end
