* BAT54 manufacturer-model ADS translation fixture only
.MODEL BAT54 D Is=649e-9 N=1.04 RS=2.09 IKF=20e-3
+XTI=2 EG=0.58
+CJO=12.4e-12 M=0.381 VJ=0.391
+BV=50 IBV=100e-6 ISR=431e-9 NR=4.99
VIN VIN 0 DC 1
RTEST VIN ANODE 100
DTEST ANODE 0 BAT54
.END
