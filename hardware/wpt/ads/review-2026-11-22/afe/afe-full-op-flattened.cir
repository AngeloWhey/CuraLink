* CuraLink Rev A: actual LTspice run with original TI family macro-model equations
* BEGIN ORIGINAL INCLUDE hardware\rev-a\ltspice\afe\models\tlv9002-namespaced.lib
* LTspice import: identifier prefixes only, original equations unchanged
* TLV9002_TLV9002 - Rev. C
* Created by Paul Goedeke; May 01, 2018 - Revised by GPAMPS Team; 2021-06-10
* Created with Green-Williams-Lis Op Amp Macro-model Architecture
* Copyright 2018 by Texas Instruments Corporation
******************************************************
* MACRO-MODEL SIMULATED PARAMETERS:
******************************************************
* OPEN-LOOP GAIN AND PHASE VS. FREQUENCY  WITH RL, CL EFFECTS (Aol)
* UNITY GAIN BANDWIDTH (GBW)
* INPUT COMMON-MODE REJECTION RATIO VS. FREQUENCY (CMRR)
* POWER SUPPLY REJECTION RATIO VS. FREQUENCY (PSRR)
* DIFFERENTIAL INPUT IMPEDANCE (Zid)
* COMMON-MODE INPUT IMPEDANCE (Zic)
* OPEN-LOOP OUTPUT IMPEDANCE VS. FREQUENCY (Zo)
* OUTPUT CURRENT THROUGH THE SUPPLY (Iout)
* INPUT VOLTAGE NOISE DENSITY VS. FREQUENCY (en)
* INPUT CURRENT NOISE DENSITY VS. FREQUENCY (in)
* OUTPUT VOLTAGE SWING vs. OUTPUT CURRENT (Vo)
* SHORT-CIRCUIT OUTPUT CURRENT (Isc)
* QUIESCENT CURRENT (Iq)
* SETTLING TIME VS. CAPACITIVE LOAD (ts)
* SLEW RATE (SR)
* SMALL SIGNAL OVERSHOOT VS. CAPACITIVE LOAD
* LARGE SIGNAL RESPONSE
* OVERLOAD RECOVERY TIME (tor)
* INPUT BIAS CURRENT (Ib)
* INPUT OFFSET CURRENT (Ios)
* INPUT OFFSET VOLTAGE (Vos)
* INPUT COMMON-MODE VOLTAGE RANGE (Vcm)
* INPUT OFFSET VOLTAGE VS. INPUT COMMON-MODE VOLTAGE (Vos vs. Vcm)
* INPUT/OUTPUT ESD CELLS (ESDin, ESDout)
******************************************************
.subckt TLV9002_TLV9002 IN+ IN- VCC VEE OUT
******************************************************
* MODEL DEFINITIONS:
.model TLV9002_BB_SW VSWITCH(Ron=50 Roff=1e12 Von=700e-3 Voff=0)
.model TLV9002_ESD_SW VSWITCH(Ron=50 Roff=1e12 Von=250e-3 Voff=0)
.model TLV9002_OL_SW VSWITCH(Ron=1e-3 Roff=1e9 Von=900e-3 Voff=800e-3)
.model TLV9002_OR_SW VSWITCH(Ron=10e-3 Roff=1e9 Von=1e-3 Voff=0)
.model TLV9002_R_NOISELESS RES(T_ABS=-273.15)
******************************************************

I_OS        ESDn MID 3P
I_B         33 MID 5P
V_GRp       58 MID 180
V_GRn       59 MID -180
V_ISCp      52 MID 42
V_ISCn      53 MID -42
V_ORn       41 VCLP -1.22
V11         57 40 0
V_ORp       39 VCLP 1.22
V12         56 38 0
V4          29 OUT 0
VCM_MIN     79 VEE_B -100M
VCM_MAX     80 VCC_B 100M
I_Q         VCC VEE 60U
V_OS        22 33 396.11U
XVOS_VCM    21 22 VCC VEE TLV9002_VOS_SRC_0
C30         23 24 15.92U
R85         24 MID TLV9002_R_NOISELESS 30K
R84         24 23 TLV9002_R_NOISELESS 10K
R83         23 MID TLV9002_R_NOISELESS 1
GVCCS10     26 MID 25 MID  -1
C29         27 MID 19.89F
R82         25 27 TLV9002_R_NOISELESS 10K
R81         25 28 TLV9002_R_NOISELESS 70K
R80         28 MID TLV9002_R_NOISELESS 1
GVCCS9      28 MID 24 MID  -3.8
GVCCS4      23 MID CL_CLAMP 29  -87
R79         30 MID TLV9002_R_NOISELESS 1
XU1         31 MID MID 30 TLV9002_VCCS_LIM_ZO_0
R78         31 MID TLV9002_R_NOISELESS 101
C22         31 26 15.92F
R65         31 26 TLV9002_R_NOISELESS 10K
R64         26 MID TLV9002_R_NOISELESS 1
R63         29 30 TLV9002_R_NOISELESS 400K
XCLAWn      MID VIMON VEE_B 32 TLV9002_VCCS_LIM_CLAW-_0
Xe_n        ESDp 33 TLV9002_VNSE_0
Xi_nn       ESDn MID TLV9002_FEMT_0_0
Xi_np       MID 33 TLV9002_FEMT_0_0
S5          VEE ESDp VEE ESDp  TLV9002_S_VSWITCH_1
S4          VEE ESDn VEE ESDn  TLV9002_S_VSWITCH_2
S2          ESDn VCC ESDn VCC  TLV9002_S_VSWITCH_3
S3          ESDp VCC ESDp VCC  TLV9002_S_VSWITCH_4
C28         34 MID 1P
R77         35 34 TLV9002_R_NOISELESS 100
C27         36 MID 1P
R76         37 36 TLV9002_R_NOISELESS 100
R75         MID 38 TLV9002_R_NOISELESS 1
GVCCS8      38 MID 39 MID  -1
R74         40 MID TLV9002_R_NOISELESS 1
GVCCS7      40 MID 41 MID  -1
C25         42 MID 25F
R69         MID 42 TLV9002_R_NOISELESS 1MEG
GVCCS6      42 MID VSENSE MID  -1U
C20         CLAMP MID 151.6N
R68         MID CLAMP TLV9002_R_NOISELESS 1MEG
XVCCS_LIM_2 43 MID MID CLAMP TLV9002_VCCS_LIM_2_0
R44         MID 43 TLV9002_R_NOISELESS 1MEG
XVCCS_LIM_1 44 45 MID 43 TLV9002_VCCS_LIM_1_0
Rdummy      MID 29 TLV9002_R_NOISELESS 40K
R61         MID 46 TLV9002_R_NOISELESS 273.3609
C16         46 47 1.1018N
R58         47 46 TLV9002_R_NOISELESS 100MEG
GVCCS2      47 MID VEE_B MID  -258.98M
R57         MID 47 TLV9002_R_NOISELESS 1
R56         MID 48 TLV9002_R_NOISELESS 273.3609
C15         48 49 1.1018N
R55         49 48 TLV9002_R_NOISELESS 100MEG
GVCCS1      49 MID VCC_B MID  -258.98M
R54         MID 49 TLV9002_R_NOISELESS 1
R49         MID 50 TLV9002_R_NOISELESS 337.4K
C14         50 51 591.7F
R48         51 50 TLV9002_R_NOISELESS 100MEG
G_adjust    51 MID ESDp MID  -44.81M
Rsrc        MID 51 TLV9002_R_NOISELESS 1
XIQPos      VIMON MID MID VCC TLV9002_VCCS_LIMIT_IQ_0
XIQNeg      MID VIMON VEE MID TLV9002_VCCS_LIMIT_IQ_0
C_DIFF      ESDp ESDn 1P
XCL_AMP     52 53 VIMON MID 54 55 TLV9002_CLAMP_AMP_LO_0
SOR_SWp     CLAMP 56 CLAMP 56  TLV9002_S_VSWITCH_5
SOR_SWn     57 CLAMP 57 CLAMP  TLV9002_S_VSWITCH_6
XGR_AMP     58 59 60 MID 61 62 TLV9002_CLAMP_AMP_HI_0
R39         58 MID TLV9002_R_NOISELESS 1T
R37         59 MID TLV9002_R_NOISELESS 1T
R42         VSENSE 60 TLV9002_R_NOISELESS 1M
C19         60 MID 1F
R38         61 MID TLV9002_R_NOISELESS 1
R36         MID 62 TLV9002_R_NOISELESS 1
R40         61 63 TLV9002_R_NOISELESS 1M
R41         62 64 TLV9002_R_NOISELESS 1M
C17         63 MID 1F
C18         MID 64 1F
XGR_SRC     63 64 CLAMP MID TLV9002_VCCS_LIM_GR_0
R21         54 MID TLV9002_R_NOISELESS 1
R20         MID 55 TLV9002_R_NOISELESS 1
R29         54 65 TLV9002_R_NOISELESS 1M
R30         55 66 TLV9002_R_NOISELESS 1M
C9          65 MID 1F
C8          MID 66 1F
XCL_SRC     65 66 CL_CLAMP MID TLV9002_VCCS_LIM_4_0
R22         52 MID TLV9002_R_NOISELESS 1T
R19         MID 53 TLV9002_R_NOISELESS 1T
XCLAWp      VIMON MID 67 VCC_B TLV9002_VCCS_LIM_CLAW+_0
R12         67 VCC_B TLV9002_R_NOISELESS 1K
R16         67 68 TLV9002_R_NOISELESS 1M
R13         VEE_B 32 TLV9002_R_NOISELESS 1K
R17         69 32 TLV9002_R_NOISELESS 1M
C6          69 MID 1F
C5          MID 68 1F
G2          VCC_CLP MID 68 MID  -1M
R15         VCC_CLP MID TLV9002_R_NOISELESS 1K
G3          VEE_CLP MID 69 MID  -1M
R14         MID VEE_CLP TLV9002_R_NOISELESS 1K
XCLAW_AMP   VCC_CLP VEE_CLP VOUT_S MID 70 71 TLV9002_CLAMP_AMP_LO_0
R26         VCC_CLP MID TLV9002_R_NOISELESS 1T
R23         VEE_CLP MID TLV9002_R_NOISELESS 1T
R25         70 MID TLV9002_R_NOISELESS 1
R24         MID 71 TLV9002_R_NOISELESS 1
R27         70 72 TLV9002_R_NOISELESS 1M
R28         71 73 TLV9002_R_NOISELESS 1M
C11         72 MID 1F
C10         MID 73 1F
XCLAW_SRC   72 73 CLAW_CLAMP MID TLV9002_VCCS_LIM_3_0
H2          37 MID V11 -1
H3          35 MID V12 1
C12         SW_OL MID 100P
R32         74 SW_OL TLV9002_R_NOISELESS 100
R31         74 MID TLV9002_R_NOISELESS 1
XOL_SENSE   MID 74 36 34 TLV9002_OL_SENSE_0
S1          23 24 SW_OL MID  TLV9002_S_VSWITCH_7
H1          75 MID V4 1K
S7          VEE OUT VEE OUT  TLV9002_S_VSWITCH_8
S6          OUT VCC OUT VCC  TLV9002_S_VSWITCH_9
R11         MID 76 TLV9002_R_NOISELESS 1T
R18         76 VOUT_S TLV9002_R_NOISELESS 100
C7          VOUT_S MID 1P
E5          76 MID OUT MID  1
C13         VIMON MID 1N
R33         75 VIMON TLV9002_R_NOISELESS 100
R10         MID 75 TLV9002_R_NOISELESS 1T
R47         77 VCLP TLV9002_R_NOISELESS 100
C24         VCLP MID 100P
E4          77 MID CL_CLAMP MID  1
R46         MID CL_CLAMP TLV9002_R_NOISELESS 1K
G9          CL_CLAMP MID CLAW_CLAMP MID  -1M
R45         MID CLAW_CLAMP TLV9002_R_NOISELESS 1K
G8          CLAW_CLAMP MID 42 MID  -1M
R43         MID VSENSE TLV9002_R_NOISELESS 1K
G15         VSENSE MID CLAMP MID  -1M
C4          44 MID 1F
R9          44 78 TLV9002_R_NOISELESS 1M
R7          MID 79 TLV9002_R_NOISELESS 1T
R6          80 MID TLV9002_R_NOISELESS 1T
R8          MID 78 TLV9002_R_NOISELESS 1
XVCM_CLAMP  81 MID 78 MID 80 79 TLV9002_VCCS_EXT_LIM_0
E1          MID 0 82 0  1
R89         VEE_B 0 TLV9002_R_NOISELESS 1
R5          83 VEE_B TLV9002_R_NOISELESS 1M
C3          83 0 1F
R60         82 83 TLV9002_R_NOISELESS 1MEG
C1          82 0 100e-9
R3          82 0 TLV9002_R_NOISELESS 1T
R59         84 82 TLV9002_R_NOISELESS 1MEG
C2          84 0 1F
R4          VCC_B 84 TLV9002_R_NOISELESS 1M
R88         VCC_B 0 TLV9002_R_NOISELESS 1
G17         VEE_B 0 VEE 0  -1
G16         VCC_B 0 VCC 0  -1
R_PSR       85 81 TLV9002_R_NOISELESS 1K
G_PSR       81 85 48 46  -1M
R2          45 ESDn TLV9002_R_NOISELESS 1M
R1          85 86 TLV9002_R_NOISELESS 1M
R_CMR       21 86 TLV9002_R_NOISELESS 1K
G_CMR       86 21 50 MID  -1M
C_CMn       ESDn MID 5P
C_CMp       MID ESDp 5P
R53         ESDn MID TLV9002_R_NOISELESS 1T
R52         MID ESDp TLV9002_R_NOISELESS 1T
R35         IN- ESDn TLV9002_R_NOISELESS 10M
R34         IN+ ESDp TLV9002_R_NOISELESS 10M

.MODEL TLV9002_S_VSWITCH_1 VSWITCH (RON=50 ROFF=1T VON=500M VOFF=100M)
.MODEL TLV9002_S_VSWITCH_2 VSWITCH (RON=50 ROFF=1T VON=500M VOFF=100M)
.MODEL TLV9002_S_VSWITCH_3 VSWITCH (RON=50 ROFF=1T VON=500M VOFF=100M)
.MODEL TLV9002_S_VSWITCH_4 VSWITCH (RON=50 ROFF=1T VON=500M VOFF=100M)
.MODEL TLV9002_S_VSWITCH_5 VSWITCH (RON=10M ROFF=1T VON=10M VOFF=0)
.MODEL TLV9002_S_VSWITCH_6 VSWITCH (RON=10M ROFF=1T VON=10M VOFF=0)
.MODEL TLV9002_S_VSWITCH_7 VSWITCH (RON=1M ROFF=1T VON=500M VOFF=100M)
.MODEL TLV9002_S_VSWITCH_8 VSWITCH (RON=50 ROFF=1T VON=500M VOFF=100M)
.MODEL TLV9002_S_VSWITCH_9 VSWITCH (RON=50 ROFF=1T VON=500M VOFF=100M)

.ENDS TLV9002_TLV9002
*
.SUBCKT TLV9002_VOS_SRC_0  V+ V- REF+ REF-
E1 V+ 1 TABLE {(V(REF+, V-))} =
+(0, 0.8E-3)
+(1, 0.8E-3)
+(1.3, 0)
+(5.5, 0)
E2 1 V- TABLE {(V(V-, REF-))}=
+(-0.7, -2E-4)
+(-0.5, -2E-4)
+(-0.4, 0)
+(5.5, 0)
.ENDS TLV9002_VOS_SRC_0
*

.SUBCKT TLV9002_VCCS_LIM_ZO_0  VC+ VC- IOUT+ IOUT-
.PARAM GAIN = 100
.PARAM IPOS = 35E3
.PARAM INEG = -35E3
G1 IOUT+ IOUT- VALUE={LIMIT(GAIN*V(VC+,VC-),INEG,IPOS)}
.ENDS
*

.SUBCKT TLV9002_VCCS_LIM_CLAW-_0  VC+ VC- IOUT+ IOUT-
G1 IOUT+ IOUT- TABLE {ABS(V(VC+,VC-))} =
+(00.0000, 0.00001)
+(14.0000, 0.000379)
+(28.0000, 0.000877)
+(37.3333, 0.001382)
+(37.8000, 0.00142)
+(38.7333, 0.001493)
+(39.6667, 0.001583)
+(40.6000, 0.001703)
+(41.5333, 0.00191)
+(42.0000, 0.00204)
.ENDS TLV9002_VCCS_LIM_CLAW-_0
*

.SUBCKT TLV9002_VNSE_0  1 2
.PARAM FLW=10
.PARAM NLF=115
.PARAM NVR=27
.PARAM GLF={PWR(FLW,0.25)*NLF/1164}
.PARAM RNV={1.184*PWR(NVR,2)}
.MODEL TLV9002_DVN D KF={PWR(FLW,0.5)/1E11} IS=1.0E-16
I1 0 7 10E-3
I2 0 8 10E-3
D1 7 0 TLV9002_DVN
D2 8 0 TLV9002_DVN
E1 3 6 7 8 {GLF}
R1 3 0 1E9
R2 3 0 1E9
R3 3 6 1E9
E2 6 4 5 0 10
R4 5 0 {RNV}
R5 5 0 {RNV}
R6 3 4 1E9
R7 4 0 1E9
E3 1 2 3 4 1
.ENDS
*

.SUBCKT TLV9002_FEMT_0_0   1 2
.PARAM FLWF=0.001
.PARAM NLFF=23
.PARAM NVRF=23
.PARAM GLFF={PWR(FLWF,0.25)*NLFF/1164}
.PARAM RNVF={1.184*PWR(NVRF,2)}
.MODEL TLV9002_DVNF D KF={PWR(FLWF,0.5)/1E11} IS=1.0E-16
I1 0 7 10E-3
I2 0 8 10E-3
D1 7 0 TLV9002_DVNF
D2 8 0 TLV9002_DVNF
E1 3 6 7 8 {GLFF}
R1 3 0 1E9
R2 3 0 1E9
R3 3 6 1E9
E2 6 4 5 0 10
R4 5 0 {RNVF}
R5 5 0 {RNVF}
R6 3 4 1E9
R7 4 0 1E9
G1 1 2 3 4 1E-6
.ENDS
*

.SUBCKT TLV9002_VCCS_LIM_2_0  VC+ VC- IOUT+ IOUT-
.PARAM GAIN = 11.15E-3
.PARAM IPOS = 0.352
.PARAM INEG = -0.352
G1 IOUT+ IOUT- VALUE={LIMIT(GAIN*V(VC+,VC-),INEG,IPOS)}
.ENDS
*

.SUBCKT TLV9002_VCCS_LIM_1_0  VC+ VC- IOUT+ IOUT-
.PARAM GAIN = 1E-4
.PARAM IPOS = .5
.PARAM INEG = -.5
G1 IOUT+ IOUT- VALUE={LIMIT(GAIN*V(VC+,VC-),INEG,IPOS)}
.ENDS
*

.SUBCKT TLV9002_VCCS_LIMIT_IQ_0  VC+ VC- IOUT+ IOUT-
.PARAM GAIN = 1E-3
G1 IOUT- IOUT+ VALUE={IF( (V(VC+,VC-)<=0),0,GAIN*V(VC+,VC-) )}
.ENDS
*

.SUBCKT TLV9002_CLAMP_AMP_LO_0  VC+ VC- VIN COM VO+ VO-
.PARAM G=1
GVO+ COM VO+ VALUE = {IF(V(VIN,COM)>V(VC+,COM),((V(VIN,COM)-V(VC+,COM))*G),0)}
GVO- COM VO- VALUE = {IF(V(VIN,COM)<V(VC-,COM),((V(VC-,COM)-V(VIN,COM))*G),0)}
.ENDS
*

.SUBCKT TLV9002_CLAMP_AMP_HI_0  VC+ VC- VIN COM VO+ VO-
.PARAM G=10
GVO+ COM VO+ VALUE = {IF(V(VIN,COM)>V(VC+,COM),((V(VIN,COM)-V(VC+,COM))*G),0)}
GVO- COM VO- VALUE = {IF(V(VIN,COM)<V(VC-,COM),((V(VC-,COM)-V(VIN,COM))*G),0)}
.ENDS
*

.SUBCKT TLV9002_VCCS_LIM_GR_0  VC+ VC- IOUT+ IOUT-
.PARAM GAIN = 1
.PARAM IPOS = 0.7
.PARAM INEG = -0.7
G1 IOUT+ IOUT- VALUE={LIMIT(GAIN*V(VC+,VC-),INEG,IPOS)}
.ENDS
*

.SUBCKT TLV9002_VCCS_LIM_4_0  VC+ VC- IOUT+ IOUT-
.PARAM GAIN = 1
.PARAM IPOS = 0.8
.PARAM INEG = -0.8
G1 IOUT+ IOUT- VALUE={LIMIT(GAIN*V(VC+,VC-),INEG,IPOS)}
.ENDS
*

.SUBCKT TLV9002_VCCS_LIM_CLAW+_0  VC+ VC- IOUT+ IOUT-
G1 IOUT+ IOUT- TABLE {ABS(V(VC+,VC-))} =
+(00.00, 0.000010)
+(13.67, 0.0003467)
+(27.33, 0.0007994)
+(36.44, 0.001309)
+(36.90, 0.001351)
+(37.81, 0.001455)
+(38.72, 0.001600)
+(39.63, 0.001812)
+(40.54, 0.002117)
+(41.00, 0.002292)
.ENDS TLV9002_VCCS_LIM_CLAW+_0
*

.SUBCKT TLV9002_VCCS_LIM_3_0  VC+ VC- IOUT+ IOUT-
.PARAM GAIN = 1
.PARAM IPOS = 0.400
.PARAM INEG = -0.400
G1 IOUT+ IOUT- VALUE={LIMIT(GAIN*V(VC+,VC-),INEG,IPOS)}
.ENDS
*

.SUBCKT TLV9002_OL_SENSE_0  COM SW+ OLN  OLP
GSW+ COM SW+ VALUE = {IF((V(OLN,COM)>10E-3 | V(OLP,COM)>10E-3),1,0)}
.ENDS
*

.SUBCKT TLV9002_VCCS_EXT_LIM_0  VIN+ VIN- IOUT- IOUT+ VP+ VP-
.PARAM GAIN = 1
G1 IOUT+ IOUT- VALUE={LIMIT(GAIN*V(VIN+,VIN-),V(VP-,VIN-), V(VP+,VIN-))}
.ENDS
*

* END ORIGINAL INCLUDE
* BEGIN ORIGINAL INCLUDE hardware\rev-a\ltspice\afe\models\tlv9052-namespaced.lib
* LTspice import: identifier prefixes only, original equations unchanged
* TLV9052_TLV9052 - Rev. D
* Created by Paul Goedeke, Bala Ravi; May 22, 2019 - Revised by GPAMPS Team; 2021-06-11
* Created with Green-Williams-Lis Op Amp Macro-model Architecture
* Copyright 2019 by Texas Instruments Corporation
******************************************************
* MACRO-MODEL SIMULATED PARAMETERS:
******************************************************
* OPEN-LOOP GAIN AND PHASE VS. FREQUENCY  WITH RL, CL EFFECTS (Aol)
* UNITY GAIN BANDWIDTH (GBW)
* INPUT COMMON-MODE REJECTION RATIO VS. FREQUENCY (CMRR)
* POWER SUPPLY REJECTION RATIO VS. FREQUENCY (PSRR)
* DIFFERENTIAL INPUT IMPEDANCE (Zid)
* COMMON-MODE INPUT IMPEDANCE (Zic)
* OPEN-LOOP OUTPUT IMPEDANCE VS. FREQUENCY (Zo)
* OUTPUT CURRENT THROUGH THE SUPPLY (Iout)
* INPUT VOLTAGE NOISE DENSITY VS. FREQUENCY (en)
* INPUT CURRENT NOISE DENSITY VS. FREQUENCY (in)
* OUTPUT VOLTAGE SWING vs. OUTPUT CURRENT (Vo)
* SHORT-CIRCUIT OUTPUT CURRENT (Isc)
* QUIESCENT CURRENT (Iq)
* SETTLING TIME VS. CAPACITIVE LOAD (ts)
* SLEW RATE (SR)
* SMALL SIGNAL OVERSHOOT VS. CAPACITIVE LOAD
* LARGE SIGNAL RESPONSE
* OVERLOAD RECOVERY TIME (tor)
* INPUT BIAS CURRENT (Ib)
* INPUT OFFSET CURRENT (Ios)
* INPUT OFFSET VOLTAGE (Vos)
* INPUT COMMON-MODE VOLTAGE RANGE (Vcm)
* INPUT OFFSET VOLTAGE VS. INPUT COMMON-MODE VOLTAGE (Vos vs. Vcm)
* INPUT/OUTPUT ESD CELLS (ESDin, ESDout)
******************************************************
.subckt TLV9052_TLV9052 IN+ IN- VCC VEE OUT
******************************************************
* MODEL DEFINITIONS:
.model TLV9052_BB_SW VSWITCH(Ron=50 Roff=1e12 Von=700e-3 Voff=0)
.model TLV9052_ESD_SW VSWITCH(Ron=50 Roff=1e12 Von=250e-3 Voff=0)
.model TLV9052_OL_SW VSWITCH(Ron=1e-3 Roff=1e9 Von=900e-3 Voff=800e-3)
.model TLV9052_OR_SW VSWITCH(Ron=10e-3 Roff=1e9 Von=1e-3 Voff=0)
.model TLV9052_R_NOISELESS RES(T_ABS=-273.15)
******************************************************

I_OS        ESDn MID 1P
I_B         30 MID 2P
V_GRp       59 MID 310
V_GRn       60 MID -310
V_ISCp      53 MID 50
V_ISCn      54 MID -50
V_ORn       50 VCLP -2.6
V11         58 49 0
V_ORp       48 VCLP 2.6
V12         57 47 0
V4          42 OUT 0
VCM_MIN     79 VEE_B -100M
VCM_MAX     80 VCC_B 100M
I_Q         VCC VEE 330U
XCLAWp      VIMON MID 21 VCC_B TLV9052_VCCS_LIM_CLAW+_0
XCLAWn      MID VIMON VEE_B 22 TLV9052_VCCS_LIM_CLAW-_0
R57         MID 23 TLV9052_R_NOISELESS 1.25K
C16         23 24 6.366P
R56         24 23 TLV9052_R_NOISELESS 10MEG
G_adjust    24 MID ESDp MID  -80M
Rsrc        MID 24 TLV9052_R_NOISELESS 1
R55         MID 25 TLV9052_R_NOISELESS 44.44
C14         25 26 530.5P
R49         26 25 TLV9052_R_NOISELESS 10MEG
GVCCS3      26 MID VCC_B MID  -711.5M
R48         MID 26 TLV9052_R_NOISELESS 1
R54         MID 27 TLV9052_R_NOISELESS 20
C15         27 28 397.9P
R51         28 27 TLV9052_R_NOISELESS 10MEG
GVCCS1      28 MID VEE_B MID  -1.581
R50         MID 28 TLV9052_R_NOISELESS 1
XU1         29 30 TLV9052_VOS_DRIFT_0
XVCCS_LIM_2 31 MID MID CLAMP TLV9052_VCCS_LIM_2_0
XVOS_VCM    32 29 VCC VEE TLV9052_VOS_SRC_0
C25         33 MID 13F
C20         CLAMP MID 115N
R94         34 MID TLV9052_R_NOISELESS 1
XZo         35 MID MID 34 TLV9052_VCCS_LIM_ZO_0
R93         35 MID TLV9052_R_NOISELESS 1.111K
C33         35 36 1.59F
R92         35 36 TLV9052_R_NOISELESS 10K
R91         36 MID TLV9052_R_NOISELESS 1
GVCCS12     36 MID 37 MID  -1
C32         38 MID 15.92F
R90         37 38 TLV9052_R_NOISELESS 10K
R87         37 39 TLV9052_R_NOISELESS 40K
R86         39 MID TLV9052_R_NOISELESS 1
GVCCS11     39 MID 40 MID  -18
C31         41 40 15.92U
R85         40 MID TLV9052_R_NOISELESS 588.2
R84         40 41 TLV9052_R_NOISELESS 10K
Rdummy      MID 42 TLV9052_R_NOISELESS 40K
Rx          42 34 TLV9052_R_NOISELESS 400K
R81         41 MID TLV9052_R_NOISELESS 1
GVCCS10     41 MID CL_CLAMP 42  -89
Xe_n        ESDp 30 TLV9052_VNSE_0
S5          VEE ESDp VEE ESDp  TLV9052_S_VSWITCH_1
S4          VEE ESDn VEE ESDn  TLV9052_S_VSWITCH_2
S2          ESDn VCC ESDn VCC  TLV9052_S_VSWITCH_3
S3          ESDp VCC ESDp VCC  TLV9052_S_VSWITCH_4
C28         43 MID 1P
R77         44 43 TLV9052_R_NOISELESS 100
C27         45 MID 1P
R76         46 45 TLV9052_R_NOISELESS 100
R75         MID 47 TLV9052_R_NOISELESS 1
GVCCS8      47 MID 48 MID  -1
R74         49 MID TLV9052_R_NOISELESS 1
GVCCS7      49 MID 50 MID  -1
Xi_nn       ESDn MID TLV9052_FEMT_0
Xi_np       MID 30 TLV9052_FEMT_0
R69         MID 33 TLV9052_R_NOISELESS 1MEG
GVCCS6      33 MID VSENSE MID  -1U
R68         MID CLAMP TLV9052_R_NOISELESS 1MEG
R44         MID 31 TLV9052_R_NOISELESS 1MEG
XVCCS_LIM_1 51 52 MID 31 TLV9052_VCCS_LIM_1_0
XIQp        VIMON MID MID VCC TLV9052_VCCS_LIMIT_IQ_0
XIQn        MID VIMON VEE MID TLV9052_VCCS_LIMIT_IQ_0
C_DIFF      ESDp ESDn 2P
XCL_AMP     53 54 VIMON MID 55 56 TLV9052_CLAMP_AMP_LO_0
SOR_SWp     CLAMP 57 CLAMP 57  TLV9052_S_VSWITCH_5
SOR_SWn     58 CLAMP 58 CLAMP  TLV9052_S_VSWITCH_6
XGR_AMP     59 60 61 MID 62 63 TLV9052_CLAMP_AMP_HI_0
R39         59 MID TLV9052_R_NOISELESS 1T
R37         60 MID TLV9052_R_NOISELESS 1T
R42         VSENSE 61 TLV9052_R_NOISELESS 1M
C19         61 MID 1F
R38         62 MID TLV9052_R_NOISELESS 1
R36         MID 63 TLV9052_R_NOISELESS 1
R40         62 64 TLV9052_R_NOISELESS 1M
R41         63 65 TLV9052_R_NOISELESS 1M
C17         64 MID 1F
C18         MID 65 1F
XGR_SRC     64 65 CLAMP MID TLV9052_VCCS_LIM_GR_0
R21         55 MID TLV9052_R_NOISELESS 1
R20         MID 56 TLV9052_R_NOISELESS 1
R29         55 66 TLV9052_R_NOISELESS 1M
R30         56 67 TLV9052_R_NOISELESS 1M
C9          66 MID 1F
C8          MID 67 1F
XCL_SRC     66 67 CL_CLAMP MID TLV9052_VCCS_LIM_4_0
R22         53 MID TLV9052_R_NOISELESS 1T
R19         MID 54 TLV9052_R_NOISELESS 1T
R12         21 VCC_B TLV9052_R_NOISELESS 1K
R16         21 68 TLV9052_R_NOISELESS 1M
R13         VEE_B 22 TLV9052_R_NOISELESS 1K
R17         69 22 TLV9052_R_NOISELESS 1M
C6          69 MID 1F
C5          MID 68 1F
G2          VCC_CLP MID 68 MID  -1M
R15         VCC_CLP MID TLV9052_R_NOISELESS 1K
G3          VEE_CLP MID 69 MID  -1M
R14         MID VEE_CLP TLV9052_R_NOISELESS 1K
XCLAW_AMP   VCC_CLP VEE_CLP VOUT_S MID 70 71 TLV9052_CLAMP_AMP_LO_0
R26         VCC_CLP MID TLV9052_R_NOISELESS 1T
R23         VEE_CLP MID TLV9052_R_NOISELESS 1T
R25         70 MID TLV9052_R_NOISELESS 1
R24         MID 71 TLV9052_R_NOISELESS 1
R27         70 72 TLV9052_R_NOISELESS 1M
R28         71 73 TLV9052_R_NOISELESS 1M
C11         72 MID 1F
C10         MID 73 1F
XCLAW_SRC   72 73 CLAW_CLAMP MID TLV9052_VCCS_LIM_3_0
H2          46 MID V11 -1
H3          44 MID V12 1
C12         SW_OL MID 100P
R32         74 SW_OL TLV9052_R_NOISELESS 100
R31         74 MID TLV9052_R_NOISELESS 1
XOL_SENSE   MID 74 45 43 TLV9052_OL_SENSE_0
S1          41 40 SW_OL MID  TLV9052_S_VSWITCH_7
H1          75 MID V4 1K
S7          VEE OUT VEE OUT  TLV9052_S_VSWITCH_8
S6          OUT VCC OUT VCC  TLV9052_S_VSWITCH_9
R11         MID 76 TLV9052_R_NOISELESS 1T
R18         76 VOUT_S TLV9052_R_NOISELESS 100
C7          VOUT_S MID 1P
E5          76 MID OUT MID  1
C13         VIMON MID 100P
R33         75 VIMON TLV9052_R_NOISELESS 100
R10         MID 75 TLV9052_R_NOISELESS 1T
R47         77 VCLP TLV9052_R_NOISELESS 100
C24         VCLP MID 100P
E4          77 MID CL_CLAMP MID  1
R46         MID CL_CLAMP TLV9052_R_NOISELESS 1K
G9          CL_CLAMP MID CLAW_CLAMP MID  -1M
R45         MID CLAW_CLAMP TLV9052_R_NOISELESS 1K
G8          CLAW_CLAMP MID 33 MID  -1M
R43         MID VSENSE TLV9052_R_NOISELESS 1K
G15         VSENSE MID CLAMP MID  -1M
C4          51 MID 1F
R9          51 78 TLV9052_R_NOISELESS 1M
R7          MID 79 TLV9052_R_NOISELESS 1T
R6          80 MID TLV9052_R_NOISELESS 1T
R8          MID 78 TLV9052_R_NOISELESS 1
XVCM_CLAMP  81 MID 78 MID 80 79 TLV9052_VCCS_EXT_LIM_0
E1          MID 0 82 0  1
R89         VEE_B 0 TLV9052_R_NOISELESS 1
R5          83 VEE_B TLV9052_R_NOISELESS 1M
C3          83 0 1F
R60         82 83 TLV9052_R_NOISELESS 1MEG
C1          82 0 100e-9
R3          82 0 TLV9052_R_NOISELESS 1T
R59         84 82 TLV9052_R_NOISELESS 1MEG
C2          84 0 1F
R4          VCC_B 84 TLV9052_R_NOISELESS 1M
R88         VCC_B 0 TLV9052_R_NOISELESS 1
G17         VEE_B 0 VEE 0  -1
G16         VCC_B 0 VCC 0  -1
R_PSR       85 81 TLV9052_R_NOISELESS 1K
G_PSR       81 85 25 27  -1M
R2          52 ESDn TLV9052_R_NOISELESS 1M
R1          85 86 TLV9052_R_NOISELESS 1M
R_CMR       32 86 TLV9052_R_NOISELESS 1K
G_CMR       86 32 23 MID  -1M
C_CMn       ESDn MID 4P
C_CMp       MID ESDp 4P
R53         ESDn MID TLV9052_R_NOISELESS 1T
R52         MID ESDp TLV9052_R_NOISELESS 1T
R35         IN- ESDn TLV9052_R_NOISELESS 10M
R34         IN+ ESDp TLV9052_R_NOISELESS 10M

.MODEL TLV9052_S_VSWITCH_1 VSWITCH (RON=50 ROFF=1T VON=500M VOFF=450M)
.MODEL TLV9052_S_VSWITCH_2 VSWITCH (RON=50 ROFF=1T VON=500M VOFF=450M)
.MODEL TLV9052_S_VSWITCH_3 VSWITCH (RON=50 ROFF=1T VON=500M VOFF=450M)
.MODEL TLV9052_S_VSWITCH_4 VSWITCH (RON=50 ROFF=1T VON=500M VOFF=450M)
.MODEL TLV9052_S_VSWITCH_5 VSWITCH (RON=10M ROFF=1T VON=10M VOFF=0)
.MODEL TLV9052_S_VSWITCH_6 VSWITCH (RON=10M ROFF=1T VON=10M VOFF=0)
.MODEL TLV9052_S_VSWITCH_7 VSWITCH (RON=1M ROFF=1T VON=500M VOFF=100M)
.MODEL TLV9052_S_VSWITCH_8 VSWITCH (RON=50 ROFF=1T VON=500M VOFF=100M)
.MODEL TLV9052_S_VSWITCH_9 VSWITCH (RON=50 ROFF=1T VON=500M VOFF=100M)

.ENDS TLV9052_TLV9052
*
.SUBCKT TLV9052_VCCS_LIM_CLAW+_0  VC+ VC- IOUT+ IOUT-
G1 IOUT+ IOUT- TABLE {ABS(V(VC+,VC-))} =
+(00, 2.00E-5)
+(02, 3.00E-5)
+(05, 9.00E-5)
+(10, 1.80E-4)
+(15, 2.80E-4)
+(20, 3.80E-4)
+(25, 5.00E-4)
+(30, 6.35E-4)
+(35, 8.00E-4)
+(40, 1.01E-3)
+(42, 1.12E-3)
+(45, 1.37E-3)
+(48, 2.00E-3)
.ENDS
*

.SUBCKT TLV9052_VCCS_LIM_CLAW-_0  VC+ VC- IOUT+ IOUT-
G1 IOUT+ IOUT- TABLE {ABS(V(VC+,VC-))} =
+(00, 2.00E-5)
+(02, 3.00E-5)
+(05, 7.50E-5)
+(10, 1.55E-4)
+(15, 2.35E-4)
+(20, 3.30E-4)
+(25, 4.30E-4)
+(30, 5.40E-4)
+(35, 6.75E-4)
+(40, 8.55E-4)
+(42, 9.50E-4)
+(45, 1.18E-3)
+(47, 1.53E-3)
+(48, 2.24E-3)
.ENDS
*

.SUBCKT TLV9052_VOS_DRIFT_0  VOS+ VOS-
.PARAM DC = 3.1261E-4
.PARAM POL = -1
.PARAM DRIFT = 0.5E-6
E1 VOS+ VOS- VALUE={DC+POL*DRIFT*(TEMP-27)}
.ENDS
*

.SUBCKT TLV9052_VCCS_LIM_2_0  VC+ VC- IOUT+ IOUT-
.PARAM GAIN = 3.969E-2
.PARAM IPOS = 2.8
.PARAM INEG = -2.8
G1 IOUT+ IOUT- VALUE={LIMIT(GAIN*V(VC+,VC-),INEG,IPOS)}
.ENDS
*

.SUBCKT TLV9052_VOS_SRC_0  V+ V- REF+ REF-
E1 V+ 1 TABLE {(V(REF+, V-))} =
+(0, 0.0003)
+(1, 0.0003)
+(1.3, 0)
+(5.5, 0)
E2 1 V- TABLE {(V(V-, REF-))}=
+(-0.7, -2E-4)
+(-0.5, -2E-4)
+(-0.4, 0)
+(5.5, 0)
.ENDS TLV9052_VOS_SRC_0
*

.SUBCKT TLV9052_VCCS_LIM_ZO_0  VC+ VC- IOUT+ IOUT-
.PARAM GAIN = 10
.PARAM IPOS = 45K
.PARAM INEG = -45K
G1 IOUT+ IOUT- VALUE={LIMIT(GAIN*V(VC+,VC-),INEG,IPOS)}
.ENDS
*

.SUBCKT TLV9052_VNSE_0  1 2
.PARAM FLW= 10
.PARAM NLF= 116
.PARAM NVR=12.5
.PARAM GLF={PWR(FLW,0.25)*NLF/1164}
.PARAM RNV={1.184*PWR(NVR,2)}
.MODEL TLV9052_DVN D KF={PWR(FLW,0.5)/1E11} IS=1.0E-16
I1 0 7 10E-3
I2 0 8 10E-3
D1 7 0 TLV9052_DVN
D2 8 0 TLV9052_DVN
E1 3 6 7 8 {GLF}
R1 3 0 1E9
R2 3 0 1E9
R3 3 6 1E9
E2 6 4 5 0 10
R4 5 0 {RNV}
R5 5 0 {RNV}
R6 3 4 1E9
R7 4 0 1E9
E3 1 2 3 4 1
.ENDS
*

.SUBCKT TLV9052_FEMT_0  1 2
.PARAM FLWF=1E-3
.PARAM NLFF=18
.PARAM NVRF=18
.PARAM GLFF={PWR(FLWF,0.25)*NLFF/1164}
.PARAM RNVF={1.184*PWR(NVRF,2)}
.MODEL TLV9052_DVNF D KF={PWR(FLWF,0.5)/1E11} IS=1.0E-16
I1 0 7 10E-3
I2 0 8 10E-3
D1 7 0 TLV9052_DVNF
D2 8 0 TLV9052_DVNF
E1 3 6 7 8 {GLFF}
R1 3 0 1E9
R2 3 0 1E9
R3 3 6 1E9
E2 6 4 5 0 10
R4 5 0 {RNVF}
R5 5 0 {RNVF}
R6 3 4 1E9
R7 4 0 1E9
G1 1 2 3 4 1E-6
.ENDS
*

.SUBCKT TLV9052_VCCS_LIM_1_0  VC+ VC- IOUT+ IOUT-
.PARAM GAIN = 1E-4
.PARAM IPOS = .5
.PARAM INEG = -.5
G1 IOUT+ IOUT- VALUE={LIMIT(GAIN*V(VC+,VC-),INEG,IPOS)}
.ENDS
*

.SUBCKT TLV9052_VCCS_LIMIT_IQ_0  VC+ VC- IOUT+ IOUT-
.PARAM GAIN = 1E-3
G1 IOUT- IOUT+ VALUE={IF( (V(VC+,VC-)<=0),0,GAIN*V(VC+,VC-) )}
.ENDS
*

.SUBCKT TLV9052_CLAMP_AMP_LO_0  VC+ VC- VIN COM VO+ VO-
.PARAM G=1
GVO+ COM VO+ VALUE = {IF(V(VIN,COM)>V(VC+,COM),((V(VIN,COM)-V(VC+,COM))*G),0)}
GVO- COM VO- VALUE = {IF(V(VIN,COM)<V(VC-,COM),((V(VC-,COM)-V(VIN,COM))*G),0)}
.ENDS
*

.SUBCKT TLV9052_CLAMP_AMP_HI_0  VC+ VC- VIN COM VO+ VO-
.PARAM G=10
GVO+ COM VO+ VALUE = {IF(V(VIN,COM)>V(VC+,COM),((V(VIN,COM)-V(VC+,COM))*G),0)}
GVO- COM VO- VALUE = {IF(V(VIN,COM)<V(VC-,COM),((V(VC-,COM)-V(VIN,COM))*G),0)}
.ENDS
*

.SUBCKT TLV9052_VCCS_LIM_GR_0  VC+ VC- IOUT+ IOUT-
.PARAM GAIN = 1
.PARAM IPOS = 4
.PARAM INEG = -4
G1 IOUT+ IOUT- VALUE={LIMIT(GAIN*V(VC+,VC-),INEG,IPOS)}
.ENDS
*

.SUBCKT TLV9052_VCCS_LIM_4_0  VC+ VC- IOUT+ IOUT-
.PARAM GAIN = 1
.PARAM IPOS = 1.8
.PARAM INEG = -1.8
G1 IOUT+ IOUT- VALUE={LIMIT(GAIN*V(VC+,VC-),INEG,IPOS)}
.ENDS
*

.SUBCKT TLV9052_VCCS_LIM_3_0  VC+ VC- IOUT+ IOUT-
.PARAM GAIN = 1
.PARAM IPOS = 740E-3
.PARAM INEG = -740E-3
G1 IOUT+ IOUT- VALUE={LIMIT(GAIN*V(VC+,VC-),INEG,IPOS)}
.ENDS
*

.SUBCKT TLV9052_OL_SENSE_0  COM SW+ OLN  OLP
GSW+ COM SW+ VALUE = {IF((V(OLN,COM)>10E-3 | V(OLP,COM)>10E-3),1,0)}
.ENDS
*

.SUBCKT TLV9052_VCCS_EXT_LIM_0  VIN+ VIN- IOUT- IOUT+ VP+ VP-
.PARAM GAIN = 1
G1 IOUT+ IOUT- VALUE={LIMIT(GAIN*V(VIN+,VIN-),V(VP-,VIN-), V(VP+,VIN-))}
.ENDS
*

* END ORIGINAL INCLUDE
.options numdgt=7 plotwinsize=0
.temp 27
* BEGIN ORIGINAL INCLUDE hardware\rev-a\ltspice\afe\canonical-afe.lib
* Exact canonical AFE passives/amplifier units + VMID divider/filter + MCU 150R/470pF interfaces
R1001 FFC_CH1 CH1_LIMIT 5100
C1001 CH1_LIMIT CH1_PLUS 1e-08
R1002 CH1_PLUS VMID 22000000
R1003 CH1_MINUS VMID 1000
R1004 CH1_PRE CH1_MINUS 10000
C1002 CH1_PRE CH1_HP_CH 1e-08
R1005 CH1_HP_CH CH1_DIFF_MINUS 51100
R1006 CH1_HP CH1_DIFF_FB_MID 909000
R1007 CH1_DIFF_FB_MID CH1_DIFF_MINUS 909000
C1003 REF_PRE CH1_HP_REF 1e-08
R1008 CH1_HP_REF CH1_DIFF_PLUS 51100
R1009 CH1_DIFF_PLUS CH1_DIFF_BAL_MID 909000
R1010 CH1_DIFF_BAL_MID VMID 909000
R1011 CH1_HP CH1_LP1_A 22600
R1012 CH1_LP1_A CH1_LP1_PLUS 22600
C1004 CH1_LP1_A CH1_LP1_OUT 1e-09
C1005 CH1_LP1_PLUS VMID 1e-09
R1013 CH1_LP1_MINUS VMID 10000
R1014 CH1_LP1_OUT CH1_LP1_MINUS 1500
R1015 CH1_LP1_OUT CH1_LP2_A 22600
R1016 CH1_LP2_A CH1_LP2_PLUS 22600
C1006 CH1_LP2_A AFE_OUT_1 1e-09
C1007 CH1_LP2_PLUS VMID 1e-09
R1017 CH1_LP2_MINUS VMID 10000
R1018 AFE_OUT_1 CH1_LP2_MINUS 12400
R1019 FFC_CH2 CH2_LIMIT 5100
C1008 CH2_LIMIT CH2_PLUS 1e-08
R1020 CH2_PLUS VMID 22000000
R1021 CH2_MINUS VMID 1000
R1022 CH2_PRE CH2_MINUS 10000
C1009 CH2_PRE CH2_HP_CH 1e-08
R1023 CH2_HP_CH CH2_DIFF_MINUS 51100
R1024 CH2_HP CH2_DIFF_FB_MID 909000
R1025 CH2_DIFF_FB_MID CH2_DIFF_MINUS 909000
C1010 REF_PRE CH2_HP_REF 1e-08
R1026 CH2_HP_REF CH2_DIFF_PLUS 51100
R1027 CH2_DIFF_PLUS CH2_DIFF_BAL_MID 909000
R1028 CH2_DIFF_BAL_MID VMID 909000
R1029 CH2_HP CH2_LP1_A 22600
R1030 CH2_LP1_A CH2_LP1_PLUS 22600
C1011 CH2_LP1_A CH2_LP1_OUT 1e-09
C1012 CH2_LP1_PLUS VMID 1e-09
R1031 CH2_LP1_MINUS VMID 10000
R1032 CH2_LP1_OUT CH2_LP1_MINUS 1500
R1033 CH2_LP1_OUT CH2_LP2_A 22600
R1034 CH2_LP2_A CH2_LP2_PLUS 22600
C1013 CH2_LP2_A AFE_OUT_2 1e-09
C1014 CH2_LP2_PLUS VMID 1e-09
R1035 CH2_LP2_MINUS VMID 10000
R1036 AFE_OUT_2 CH2_LP2_MINUS 12400
R1037 FFC_CH3 CH3_LIMIT 5100
C1015 CH3_LIMIT CH3_PLUS 1e-08
R1038 CH3_PLUS VMID 22000000
R1039 CH3_MINUS VMID 1000
R1040 CH3_PRE CH3_MINUS 10000
C1016 CH3_PRE CH3_HP_CH 1e-08
R1041 CH3_HP_CH CH3_DIFF_MINUS 51100
R1042 CH3_HP CH3_DIFF_FB_MID 909000
R1043 CH3_DIFF_FB_MID CH3_DIFF_MINUS 909000
C1017 REF_PRE CH3_HP_REF 1e-08
R1044 CH3_HP_REF CH3_DIFF_PLUS 51100
R1045 CH3_DIFF_PLUS CH3_DIFF_BAL_MID 909000
R1046 CH3_DIFF_BAL_MID VMID 909000
R1047 CH3_HP CH3_LP1_A 22600
R1048 CH3_LP1_A CH3_LP1_PLUS 22600
C1018 CH3_LP1_A CH3_LP1_OUT 1e-09
C1019 CH3_LP1_PLUS VMID 1e-09
R1049 CH3_LP1_MINUS VMID 10000
R1050 CH3_LP1_OUT CH3_LP1_MINUS 1500
R1051 CH3_LP1_OUT CH3_LP2_A 22600
R1052 CH3_LP2_A CH3_LP2_PLUS 22600
C1020 CH3_LP2_A AFE_OUT_3 1e-09
C1021 CH3_LP2_PLUS VMID 1e-09
R1053 CH3_LP2_MINUS VMID 10000
R1054 AFE_OUT_3 CH3_LP2_MINUS 12400
R1055 FFC_CH4 CH4_LIMIT 5100
C1022 CH4_LIMIT CH4_PLUS 1e-08
R1056 CH4_PLUS VMID 22000000
R1057 CH4_MINUS VMID 1000
R1058 CH4_PRE CH4_MINUS 10000
C1023 CH4_PRE CH4_HP_CH 1e-08
R1059 CH4_HP_CH CH4_DIFF_MINUS 51100
R1060 CH4_HP CH4_DIFF_FB_MID 909000
R1061 CH4_DIFF_FB_MID CH4_DIFF_MINUS 909000
C1024 REF_PRE CH4_HP_REF 1e-08
R1062 CH4_HP_REF CH4_DIFF_PLUS 51100
R1063 CH4_DIFF_PLUS CH4_DIFF_BAL_MID 909000
R1064 CH4_DIFF_BAL_MID VMID 909000
R1065 CH4_HP CH4_LP1_A 22600
R1066 CH4_LP1_A CH4_LP1_PLUS 22600
C1025 CH4_LP1_A CH4_LP1_OUT 1e-09
C1026 CH4_LP1_PLUS VMID 1e-09
R1067 CH4_LP1_MINUS VMID 10000
R1068 CH4_LP1_OUT CH4_LP1_MINUS 1500
R1069 CH4_LP1_OUT CH4_LP2_A 22600
R1070 CH4_LP2_A CH4_LP2_PLUS 22600
C1027 CH4_LP2_A AFE_OUT_4 1e-09
C1028 CH4_LP2_PLUS VMID 1e-09
R1071 CH4_LP2_MINUS VMID 10000
R1072 AFE_OUT_4 CH4_LP2_MINUS 12400
R1073 FFC_CH5 CH5_LIMIT 5100
C1029 CH5_LIMIT CH5_PLUS 1e-08
R1074 CH5_PLUS VMID 22000000
R1075 CH5_MINUS VMID 1000
R1076 CH5_PRE CH5_MINUS 10000
C1030 CH5_PRE CH5_HP_CH 1e-08
R1077 CH5_HP_CH CH5_DIFF_MINUS 51100
R1078 CH5_HP CH5_DIFF_FB_MID 909000
R1079 CH5_DIFF_FB_MID CH5_DIFF_MINUS 909000
C1031 REF_PRE CH5_HP_REF 1e-08
R1080 CH5_HP_REF CH5_DIFF_PLUS 51100
R1081 CH5_DIFF_PLUS CH5_DIFF_BAL_MID 909000
R1082 CH5_DIFF_BAL_MID VMID 909000
R1083 CH5_HP CH5_LP1_A 22600
R1084 CH5_LP1_A CH5_LP1_PLUS 22600
C1032 CH5_LP1_A CH5_LP1_OUT 1e-09
C1033 CH5_LP1_PLUS VMID 1e-09
R1085 CH5_LP1_MINUS VMID 10000
R1086 CH5_LP1_OUT CH5_LP1_MINUS 1500
R1087 CH5_LP1_OUT CH5_LP2_A 22600
R1088 CH5_LP2_A CH5_LP2_PLUS 22600
C1034 CH5_LP2_A AFE_OUT_5 1e-09
C1035 CH5_LP2_PLUS VMID 1e-09
R1089 CH5_LP2_MINUS VMID 10000
R1090 AFE_OUT_5 CH5_LP2_MINUS 12400
R1091 FFC_CH6 CH6_LIMIT 5100
C1036 CH6_LIMIT CH6_PLUS 1e-08
R1092 CH6_PLUS VMID 22000000
R1093 CH6_MINUS VMID 1000
R1094 CH6_PRE CH6_MINUS 10000
C1037 CH6_PRE CH6_HP_CH 1e-08
R1095 CH6_HP_CH CH6_DIFF_MINUS 51100
R1096 CH6_HP CH6_DIFF_FB_MID 909000
R1097 CH6_DIFF_FB_MID CH6_DIFF_MINUS 909000
C1038 REF_PRE CH6_HP_REF 1e-08
R1098 CH6_HP_REF CH6_DIFF_PLUS 51100
R1099 CH6_DIFF_PLUS CH6_DIFF_BAL_MID 909000
R1100 CH6_DIFF_BAL_MID VMID 909000
R1101 CH6_HP CH6_LP1_A 22600
R1102 CH6_LP1_A CH6_LP1_PLUS 22600
C1039 CH6_LP1_A CH6_LP1_OUT 1e-09
C1040 CH6_LP1_PLUS VMID 1e-09
R1103 CH6_LP1_MINUS VMID 10000
R1104 CH6_LP1_OUT CH6_LP1_MINUS 1500
R1105 CH6_LP1_OUT CH6_LP2_A 22600
R1106 CH6_LP2_A CH6_LP2_PLUS 22600
C1041 CH6_LP2_A AFE_OUT_6 1e-09
C1042 CH6_LP2_PLUS VMID 1e-09
R1107 CH6_LP2_MINUS VMID 10000
R1108 AFE_OUT_6 CH6_LP2_MINUS 12400
R1109 FFC_CH7 CH7_LIMIT 5100
C1043 CH7_LIMIT CH7_PLUS 1e-08
R1110 CH7_PLUS VMID 22000000
R1111 CH7_MINUS VMID 1000
R1112 CH7_PRE CH7_MINUS 10000
C1044 CH7_PRE CH7_HP_CH 1e-08
R1113 CH7_HP_CH CH7_DIFF_MINUS 51100
R1114 CH7_HP CH7_DIFF_FB_MID 909000
R1115 CH7_DIFF_FB_MID CH7_DIFF_MINUS 909000
C1045 REF_PRE CH7_HP_REF 1e-08
R1116 CH7_HP_REF CH7_DIFF_PLUS 51100
R1117 CH7_DIFF_PLUS CH7_DIFF_BAL_MID 909000
R1118 CH7_DIFF_BAL_MID VMID 909000
R1119 CH7_HP CH7_LP1_A 22600
R1120 CH7_LP1_A CH7_LP1_PLUS 22600
C1046 CH7_LP1_A CH7_LP1_OUT 1e-09
C1047 CH7_LP1_PLUS VMID 1e-09
R1121 CH7_LP1_MINUS VMID 10000
R1122 CH7_LP1_OUT CH7_LP1_MINUS 1500
R1123 CH7_LP1_OUT CH7_LP2_A 22600
R1124 CH7_LP2_A CH7_LP2_PLUS 22600
C1048 CH7_LP2_A AFE_OUT_7 1e-09
C1049 CH7_LP2_PLUS VMID 1e-09
R1125 CH7_LP2_MINUS VMID 10000
R1126 AFE_OUT_7 CH7_LP2_MINUS 12400
R1127 FFC_CH8 CH8_LIMIT 5100
C1050 CH8_LIMIT CH8_PLUS 1e-08
R1128 CH8_PLUS VMID 22000000
R1129 CH8_MINUS VMID 1000
R1130 CH8_PRE CH8_MINUS 10000
C1051 CH8_PRE CH8_HP_CH 1e-08
R1131 CH8_HP_CH CH8_DIFF_MINUS 51100
R1132 CH8_HP CH8_DIFF_FB_MID 909000
R1133 CH8_DIFF_FB_MID CH8_DIFF_MINUS 909000
C1052 REF_PRE CH8_HP_REF 1e-08
R1134 CH8_HP_REF CH8_DIFF_PLUS 51100
R1135 CH8_DIFF_PLUS CH8_DIFF_BAL_MID 909000
R1136 CH8_DIFF_BAL_MID VMID 909000
R1137 CH8_HP CH8_LP1_A 22600
R1138 CH8_LP1_A CH8_LP1_PLUS 22600
C1053 CH8_LP1_A CH8_LP1_OUT 1e-09
C1054 CH8_LP1_PLUS VMID 1e-09
R1139 CH8_LP1_MINUS VMID 10000
R1140 CH8_LP1_OUT CH8_LP1_MINUS 1500
R1141 CH8_LP1_OUT CH8_LP2_A 22600
R1142 CH8_LP2_A CH8_LP2_PLUS 22600
C1055 CH8_LP2_A AFE_OUT_8 1e-09
C1056 CH8_LP2_PLUS VMID 1e-09
R1143 CH8_LP2_MINUS VMID 10000
R1144 AFE_OUT_8 CH8_LP2_MINUS 12400
R1145 FFC_REF REF_LIMIT 5100
C1057 REF_LIMIT REF_PLUS 1e-08
R1146 REF_PLUS VMID 22000000
R1147 REF_MINUS VMID 1000
R1148 REF_PRE REF_MINUS 10000
R1149 VMID_BUF VMID 47
C1058 VMID 0 4.7e-06
XU101_1 CH1_PLUS CH1_MINUS AVDD_3V0 0 CH1_PRE TLV9002_TLV9002
XU101_2 CH2_PLUS CH2_MINUS AVDD_3V0 0 CH2_PRE TLV9002_TLV9002
XU101_3 CH3_PLUS CH3_MINUS AVDD_3V0 0 CH3_PRE TLV9002_TLV9002
XU101_4 CH4_PLUS CH4_MINUS AVDD_3V0 0 CH4_PRE TLV9002_TLV9002
C1059 AVDD_3V0 0 1e-07
XU102_1 CH5_PLUS CH5_MINUS AVDD_3V0 0 CH5_PRE TLV9002_TLV9002
XU102_2 CH6_PLUS CH6_MINUS AVDD_3V0 0 CH6_PRE TLV9002_TLV9002
XU102_3 CH7_PLUS CH7_MINUS AVDD_3V0 0 CH7_PRE TLV9002_TLV9002
XU102_4 CH8_PLUS CH8_MINUS AVDD_3V0 0 CH8_PRE TLV9002_TLV9002
C1060 AVDD_3V0 0 1e-07
XU103_1 CH1_DIFF_PLUS CH1_DIFF_MINUS AVDD_3V0 0 CH1_HP TLV9002_TLV9002
XU103_2 CH2_DIFF_PLUS CH2_DIFF_MINUS AVDD_3V0 0 CH2_HP TLV9002_TLV9002
XU103_3 CH3_DIFF_PLUS CH3_DIFF_MINUS AVDD_3V0 0 CH3_HP TLV9002_TLV9002
XU103_4 CH4_DIFF_PLUS CH4_DIFF_MINUS AVDD_3V0 0 CH4_HP TLV9002_TLV9002
C1061 AVDD_3V0 0 1e-07
XU104_1 CH5_DIFF_PLUS CH5_DIFF_MINUS AVDD_3V0 0 CH5_HP TLV9002_TLV9002
XU104_2 CH6_DIFF_PLUS CH6_DIFF_MINUS AVDD_3V0 0 CH6_HP TLV9002_TLV9002
XU104_3 CH7_DIFF_PLUS CH7_DIFF_MINUS AVDD_3V0 0 CH7_HP TLV9002_TLV9002
XU104_4 CH8_DIFF_PLUS CH8_DIFF_MINUS AVDD_3V0 0 CH8_HP TLV9002_TLV9002
C1062 AVDD_3V0 0 1e-07
XU105_1 CH1_LP1_PLUS CH1_LP1_MINUS AVDD_3V0 0 CH1_LP1_OUT TLV9002_TLV9002
XU105_2 CH2_LP1_PLUS CH2_LP1_MINUS AVDD_3V0 0 CH2_LP1_OUT TLV9002_TLV9002
XU105_3 CH3_LP1_PLUS CH3_LP1_MINUS AVDD_3V0 0 CH3_LP1_OUT TLV9002_TLV9002
XU105_4 CH4_LP1_PLUS CH4_LP1_MINUS AVDD_3V0 0 CH4_LP1_OUT TLV9002_TLV9002
C1063 AVDD_3V0 0 1e-07
XU106_1 CH5_LP1_PLUS CH5_LP1_MINUS AVDD_3V0 0 CH5_LP1_OUT TLV9002_TLV9002
XU106_2 CH6_LP1_PLUS CH6_LP1_MINUS AVDD_3V0 0 CH6_LP1_OUT TLV9002_TLV9002
XU106_3 CH7_LP1_PLUS CH7_LP1_MINUS AVDD_3V0 0 CH7_LP1_OUT TLV9002_TLV9002
XU106_4 CH8_LP1_PLUS CH8_LP1_MINUS AVDD_3V0 0 CH8_LP1_OUT TLV9002_TLV9002
C1064 AVDD_3V0 0 1e-07
XU107_1 CH1_LP2_PLUS CH1_LP2_MINUS AVDD_3V0 0 AFE_OUT_1 TLV9052_TLV9052
XU107_2 CH2_LP2_PLUS CH2_LP2_MINUS AVDD_3V0 0 AFE_OUT_2 TLV9052_TLV9052
XU107_3 CH3_LP2_PLUS CH3_LP2_MINUS AVDD_3V0 0 AFE_OUT_3 TLV9052_TLV9052
XU107_4 CH4_LP2_PLUS CH4_LP2_MINUS AVDD_3V0 0 AFE_OUT_4 TLV9052_TLV9052
C1065 AVDD_3V0 0 1e-07
XU108_1 CH5_LP2_PLUS CH5_LP2_MINUS AVDD_3V0 0 AFE_OUT_5 TLV9052_TLV9052
XU108_2 CH6_LP2_PLUS CH6_LP2_MINUS AVDD_3V0 0 AFE_OUT_6 TLV9052_TLV9052
XU108_3 CH7_LP2_PLUS CH7_LP2_MINUS AVDD_3V0 0 AFE_OUT_7 TLV9052_TLV9052
XU108_4 CH8_LP2_PLUS CH8_LP2_MINUS AVDD_3V0 0 AFE_OUT_8 TLV9052_TLV9052
C1066 AVDD_3V0 0 1e-07
XU109_1 REF_PLUS REF_MINUS AVDD_3V0 0 REF_PRE TLV9002_TLV9002
XU109_2 VMID_RAW VMID_BUF AVDD_3V0 0 VMID_BUF TLV9002_TLV9002
XU109_3 VMID_RAW AFE_SPARE_C AVDD_3V0 0 AFE_SPARE_C TLV9002_TLV9002
XU109_4 VMID_RAW AFE_SPARE_D AVDD_3V0 0 AFE_SPARE_D TLV9002_TLV9002
C1067 AVDD_3V0 0 1e-07
C1068 AVDD_3V0 0 4.7e-06
R540 AVDD_3V0 VMID_RAW 10000
R541 VMID_RAW 0 10000
C529 VMID_RAW 0 2.2e-06
R401 AFE_OUT_1 ADC_IN_1 150
C413 ADC_IN_1 0 4.7e-10
R402 AFE_OUT_2 ADC_IN_2 150
C414 ADC_IN_2 0 4.7e-10
R403 AFE_OUT_3 ADC_IN_3 150
C415 ADC_IN_3 0 4.7e-10
R404 AFE_OUT_4 ADC_IN_4 150
C416 ADC_IN_4 0 4.7e-10
R405 AFE_OUT_5 ADC_IN_5 150
C417 ADC_IN_5 0 4.7e-10
R406 AFE_OUT_6 ADC_IN_6 150
C418 ADC_IN_6 0 4.7e-10
R407 AFE_OUT_7 ADC_IN_7 150
C419 ADC_IN_7 0 4.7e-10
R408 AFE_OUT_8 ADC_IN_8 150
C420 ADC_IN_8 0 4.7e-10
* External ESD clamp is capacitance-only; does not establish overvoltage/fault clamp behavior
R_SOURCE_CH1 SRC_CH1 FFC_CH1 47k
C_FFC_CH1 FFC_CH1 0 20p
C_TRACE_CH1 FFC_CH1 0 2p
C_ESD_CH1 FFC_CH1 0 0.5p
R_SOURCE_CH2 SRC_CH2 FFC_CH2 47k
C_FFC_CH2 FFC_CH2 0 20p
C_TRACE_CH2 FFC_CH2 0 2p
C_ESD_CH2 FFC_CH2 0 0.5p
R_SOURCE_CH3 SRC_CH3 FFC_CH3 47k
C_FFC_CH3 FFC_CH3 0 20p
C_TRACE_CH3 FFC_CH3 0 2p
C_ESD_CH3 FFC_CH3 0 0.5p
R_SOURCE_CH4 SRC_CH4 FFC_CH4 47k
C_FFC_CH4 FFC_CH4 0 20p
C_TRACE_CH4 FFC_CH4 0 2p
C_ESD_CH4 FFC_CH4 0 0.5p
R_SOURCE_CH5 SRC_CH5 FFC_CH5 47k
C_FFC_CH5 FFC_CH5 0 20p
C_TRACE_CH5 FFC_CH5 0 2p
C_ESD_CH5 FFC_CH5 0 0.5p
R_SOURCE_CH6 SRC_CH6 FFC_CH6 47k
C_FFC_CH6 FFC_CH6 0 20p
C_TRACE_CH6 FFC_CH6 0 2p
C_ESD_CH6 FFC_CH6 0 0.5p
R_SOURCE_CH7 SRC_CH7 FFC_CH7 47k
C_FFC_CH7 FFC_CH7 0 20p
C_TRACE_CH7 FFC_CH7 0 2p
C_ESD_CH7 FFC_CH7 0 0.5p
R_SOURCE_CH8 SRC_CH8 FFC_CH8 47k
C_FFC_CH8 FFC_CH8 0 20p
C_TRACE_CH8 FFC_CH8 0 2p
C_ESD_CH8 FFC_CH8 0 0.5p
R_SOURCE_REF SRC_REF FFC_REF 47k
C_FFC_REF FFC_REF 0 20p
C_TRACE_REF FFC_REF 0 2p
C_ESD_REF FFC_REF 0 0.5p

* END ORIGINAL INCLUDE
VDD AVDD_3V0 0 DC 3
VCOMMON COMMON_SRC 0 DC 0 AC 0
VCH1 SRC_CH1 COMMON_SRC DC 0 AC 0
VCH2 SRC_CH2 COMMON_SRC DC 0 AC 0
VCH3 SRC_CH3 COMMON_SRC DC 0 AC 0
VCH4 SRC_CH4 COMMON_SRC DC 0 AC 0
VCH5 SRC_CH5 COMMON_SRC DC 0 AC 0
VCH6 SRC_CH6 COMMON_SRC DC 0 AC 0
VCH7 SRC_CH7 COMMON_SRC DC 0 AC 0
VCH8 SRC_CH8 COMMON_SRC DC 0 AC 0
VREF SRC_REF COMMON_SRC DC 0 AC 0
.save V(AVDD_3V0) V(VMID_RAW) V(VMID_BUF) V(VMID) V(REF_PLUS) V(REF_PRE) V(CH1_PLUS) V(CH1_MINUS) V(CH1_PRE) V(CH1_DIFF_PLUS) V(CH1_DIFF_MINUS) V(CH1_HP) V(CH1_LP1_OUT) V(AFE_OUT_1) V(ADC_IN_1) V(FFC_CH1) V(SRC_CH1) V(SRC_REF) I(VDD) V(AFE_OUT_2) V(AFE_OUT_3) V(AFE_OUT_4) V(AFE_OUT_5) V(AFE_OUT_6) V(AFE_OUT_7) V(AFE_OUT_8) V(AFE_OUT_1) V(AFE_OUT_2) V(AFE_OUT_3) V(AFE_OUT_4) V(AFE_OUT_5) V(AFE_OUT_6) V(AFE_OUT_7) V(AFE_OUT_8) V(AFE_SPARE_C) V(AFE_SPARE_D) V(CH1_DIFF_MINUS) V(CH1_DIFF_PLUS) V(CH1_HP) V(CH1_LP1_MINUS) V(CH1_LP1_OUT) V(CH1_LP1_PLUS) V(CH1_LP2_MINUS) V(CH1_LP2_PLUS) V(CH1_MINUS) V(CH1_PLUS) V(CH1_PRE) V(CH2_DIFF_MINUS) V(CH2_DIFF_PLUS) V(CH2_HP) V(CH2_LP1_MINUS) V(CH2_LP1_OUT) V(CH2_LP1_PLUS) V(CH2_LP2_MINUS) V(CH2_LP2_PLUS) V(CH2_MINUS) V(CH2_PLUS) V(CH2_PRE) V(CH3_DIFF_MINUS) V(CH3_DIFF_PLUS) V(CH3_HP) V(CH3_LP1_MINUS) V(CH3_LP1_OUT) V(CH3_LP1_PLUS) V(CH3_LP2_MINUS) V(CH3_LP2_PLUS) V(CH3_MINUS) V(CH3_PLUS) V(CH3_PRE) V(CH4_DIFF_MINUS) V(CH4_DIFF_PLUS) V(CH4_HP) V(CH4_LP1_MINUS) V(CH4_LP1_OUT) V(CH4_LP1_PLUS) V(CH4_LP2_MINUS) V(CH4_LP2_PLUS) V(CH4_MINUS) V(CH4_PLUS) V(CH4_PRE) V(CH5_DIFF_MINUS) V(CH5_DIFF_PLUS) V(CH5_HP) V(CH5_LP1_MINUS) V(CH5_LP1_OUT) V(CH5_LP1_PLUS) V(CH5_LP2_MINUS) V(CH5_LP2_PLUS) V(CH5_MINUS) V(CH5_PLUS) V(CH5_PRE) V(CH6_DIFF_MINUS) V(CH6_DIFF_PLUS) V(CH6_HP) V(CH6_LP1_MINUS) V(CH6_LP1_OUT) V(CH6_LP1_PLUS) V(CH6_LP2_MINUS) V(CH6_LP2_PLUS) V(CH6_MINUS) V(CH6_PLUS) V(CH6_PRE) V(CH7_DIFF_MINUS) V(CH7_DIFF_PLUS) V(CH7_HP) V(CH7_LP1_MINUS) V(CH7_LP1_OUT) V(CH7_LP1_PLUS) V(CH7_LP2_MINUS) V(CH7_LP2_PLUS) V(CH7_MINUS) V(CH7_PLUS) V(CH7_PRE) V(CH8_DIFF_MINUS) V(CH8_DIFF_PLUS) V(CH8_HP) V(CH8_LP1_MINUS) V(CH8_LP1_OUT) V(CH8_LP1_PLUS) V(CH8_LP2_MINUS) V(CH8_LP2_PLUS) V(CH8_MINUS) V(CH8_PLUS) V(CH8_PRE) V(REF_MINUS) V(REF_PLUS) V(REF_PRE) V(VMID_BUF) V(VMID_RAW)
.op
.end
